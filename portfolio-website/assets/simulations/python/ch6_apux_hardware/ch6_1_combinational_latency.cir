* ============================================================
* ch6_1_combinational_latency.cir
* 250-Stage 14 nm FinFET CMOS Inverter Chain — PVT Corner Sweep
* Purpose : Validate T_comb = 12.9 ns < 12.98 ns (77 MHz window)
*           across all 5 PVT corners (TT FF SS FS SF)
* Simulator: ngspice / LTspice (compatible netlist)
* ============================================================

* ---- Supply voltage (nominal 0.8 V for 14 nm) ----
.PARAM VDD_nom = 0.8
.PARAM VDD = {VDD_nom}

* ---- Process corner scaling factors ----
* Controlled by .PARAM corner_nmos / corner_pmos
* TT: 1.0/1.0  FF: 0.85/0.85  SS: 1.2/1.2  FS: 0.85/1.2  SF: 1.2/0.85
.PARAM corner_nmos = 1.0
.PARAM corner_pmos = 1.0

* ---- Temperature (set per run) ----
.TEMP 27

* ---- Power Supply ----
VDD VDD 0 DC {VDD}

* ---- 14 nm FinFET NMOS model (simplified BSIM-CMG level 72) ----
* In a real flow, include the PDK model card here:
*   .lib '/path/to/14nm_FinFET_PDK.lib' tt
* Below is a parameterised behavioural approximation:

.SUBCKT INV_14NM IN OUT VDD VSS
* NMOS FinFET — 1 fin, W_fin=7nm, Hfin=46nm, L=14nm
MN OUT IN VSS VSS NMOS_14NM W=7n L=14n M={corner_nmos}
* PMOS FinFET — 1 fin
MP OUT IN VDD VDD PMOS_14NM W=7n L=14n M={corner_pmos}
.ENDS INV_14NM

* ---- Simplified Level-1 MOSFET models scaled to 14 nm ----
.MODEL NMOS_14NM NMOS LEVEL=1
+  VTO=0.22  KP=600u  GAMMA=0.4  PHI=0.8
+  LAMBDA=0.1  TOX=1.2n  LD=1n  RSH=5

.MODEL PMOS_14NM PMOS LEVEL=1
+  VTO=-0.22  KP=250u  GAMMA=0.4  PHI=0.8
+  LAMBDA=0.1  TOX=1.2n  LD=1n  RSH=5

* ---- 250-Stage Inverter Chain ----
* Generate with .SUBCKT instantiation loop
* (ngspice supports .FOR loops; LTspice users: expand manually or use .STEP)

X1   IN   N1   VDD 0 INV_14NM
X2   N1   N2   VDD 0 INV_14NM
X3   N2   N3   VDD 0 INV_14NM
X4   N3   N4   VDD 0 INV_14NM
X5   N4   N5   VDD 0 INV_14NM
X6   N5   N6   VDD 0 INV_14NM
X7   N6   N7   VDD 0 INV_14NM
X8   N7   N8   VDD 0 INV_14NM
X9   N8   N9   VDD 0 INV_14NM
X10  N9   N10  VDD 0 INV_14NM
X11  N10  N11  VDD 0 INV_14NM
X12  N11  N12  VDD 0 INV_14NM
X13  N12  N13  VDD 0 INV_14NM
X14  N13  N14  VDD 0 INV_14NM
X15  N14  N15  VDD 0 INV_14NM
X16  N15  N16  VDD 0 INV_14NM
X17  N16  N17  VDD 0 INV_14NM
X18  N17  N18  VDD 0 INV_14NM
X19  N18  N19  VDD 0 INV_14NM
X20  N19  N20  VDD 0 INV_14NM
X21  N20  N21  VDD 0 INV_14NM
X22  N21  N22  VDD 0 INV_14NM
X23  N22  N23  VDD 0 INV_14NM
X24  N23  N24  VDD 0 INV_14NM
X25  N24  N25  VDD 0 INV_14NM
X26  N25  N26  VDD 0 INV_14NM
X27  N26  N27  VDD 0 INV_14NM
X28  N27  N28  VDD 0 INV_14NM
X29  N28  N29  VDD 0 INV_14NM
X30  N29  N30  VDD 0 INV_14NM
X31  N30  N31  VDD 0 INV_14NM
X32  N31  N32  VDD 0 INV_14NM
X33  N32  N33  VDD 0 INV_14NM
X34  N33  N34  VDD 0 INV_14NM
X35  N34  N35  VDD 0 INV_14NM
X36  N35  N36  VDD 0 INV_14NM
X37  N36  N37  VDD 0 INV_14NM
X38  N37  N38  VDD 0 INV_14NM
X39  N38  N39  VDD 0 INV_14NM
X40  N39  N40  VDD 0 INV_14NM
X41  N40  N41  VDD 0 INV_14NM
X42  N41  N42  VDD 0 INV_14NM
X43  N42  N43  VDD 0 INV_14NM
X44  N43  N44  VDD 0 INV_14NM
X45  N44  N45  VDD 0 INV_14NM
X46  N45  N46  VDD 0 INV_14NM
X47  N46  N47  VDD 0 INV_14NM
X48  N47  N48  VDD 0 INV_14NM
X49  N48  N49  VDD 0 INV_14NM
X50  N49  N50  VDD 0 INV_14NM
X51  N50  N51  VDD 0 INV_14NM
X52  N51  N52  VDD 0 INV_14NM
X53  N52  N53  VDD 0 INV_14NM
X54  N53  N54  VDD 0 INV_14NM
X55  N54  N55  VDD 0 INV_14NM
X56  N55  N56  VDD 0 INV_14NM
X57  N56  N57  VDD 0 INV_14NM
X58  N57  N58  VDD 0 INV_14NM
X59  N58  N59  VDD 0 INV_14NM
X60  N59  N60  VDD 0 INV_14NM
X61  N60  N61  VDD 0 INV_14NM
X62  N61  N62  VDD 0 INV_14NM
X63  N62  N63  VDD 0 INV_14NM
X64  N63  N64  VDD 0 INV_14NM
X65  N64  N65  VDD 0 INV_14NM
X66  N65  N66  VDD 0 INV_14NM
X67  N66  N67  VDD 0 INV_14NM
X68  N67  N68  VDD 0 INV_14NM
X69  N68  N69  VDD 0 INV_14NM
X70  N69  N70  VDD 0 INV_14NM
X71  N70  N71  VDD 0 INV_14NM
X72  N71  N72  VDD 0 INV_14NM
X73  N72  N73  VDD 0 INV_14NM
X74  N73  N74  VDD 0 INV_14NM
X75  N74  N75  VDD 0 INV_14NM
X76  N75  N76  VDD 0 INV_14NM
X77  N76  N77  VDD 0 INV_14NM
X78  N77  N78  VDD 0 INV_14NM
X79  N78  N79  VDD 0 INV_14NM
X80  N79  N80  VDD 0 INV_14NM
X81  N80  N81  VDD 0 INV_14NM
X82  N81  N82  VDD 0 INV_14NM
X83  N82  N83  VDD 0 INV_14NM
X84  N83  N84  VDD 0 INV_14NM
X85  N84  N85  VDD 0 INV_14NM
X86  N85  N86  VDD 0 INV_14NM
X87  N86  N87  VDD 0 INV_14NM
X88  N87  N88  VDD 0 INV_14NM
X89  N88  N89  VDD 0 INV_14NM
X90  N89  N90  VDD 0 INV_14NM
X91  N90  N91  VDD 0 INV_14NM
X92  N91  N92  VDD 0 INV_14NM
X93  N92  N93  VDD 0 INV_14NM
X94  N93  N94  VDD 0 INV_14NM
X95  N94  N95  VDD 0 INV_14NM
X96  N95  N96  VDD 0 INV_14NM
X97  N96  N97  VDD 0 INV_14NM
X98  N97  N98  VDD 0 INV_14NM
X99  N98  N99  VDD 0 INV_14NM
X100 N99  N100 VDD 0 INV_14NM
X101 N100 N101 VDD 0 INV_14NM
X102 N101 N102 VDD 0 INV_14NM
X103 N102 N103 VDD 0 INV_14NM
X104 N103 N104 VDD 0 INV_14NM
X105 N104 N105 VDD 0 INV_14NM
X106 N105 N106 VDD 0 INV_14NM
X107 N106 N107 VDD 0 INV_14NM
X108 N107 N108 VDD 0 INV_14NM
X109 N108 N109 VDD 0 INV_14NM
X110 N109 N110 VDD 0 INV_14NM
X111 N110 N111 VDD 0 INV_14NM
X112 N111 N112 VDD 0 INV_14NM
X113 N112 N113 VDD 0 INV_14NM
X114 N113 N114 VDD 0 INV_14NM
X115 N114 N115 VDD 0 INV_14NM
X116 N115 N116 VDD 0 INV_14NM
X117 N116 N117 VDD 0 INV_14NM
X118 N117 N118 VDD 0 INV_14NM
X119 N118 N119 VDD 0 INV_14NM
X120 N119 N120 VDD 0 INV_14NM
X121 N120 N121 VDD 0 INV_14NM
X122 N121 N122 VDD 0 INV_14NM
X123 N122 N123 VDD 0 INV_14NM
X124 N123 N124 VDD 0 INV_14NM
X125 N124 N125 VDD 0 INV_14NM
X126 N125 N126 VDD 0 INV_14NM
X127 N126 N127 VDD 0 INV_14NM
X128 N127 N128 VDD 0 INV_14NM
X129 N128 N129 VDD 0 INV_14NM
X130 N129 N130 VDD 0 INV_14NM
X131 N130 N131 VDD 0 INV_14NM
X132 N131 N132 VDD 0 INV_14NM
X133 N132 N133 VDD 0 INV_14NM
X134 N133 N134 VDD 0 INV_14NM
X135 N134 N135 VDD 0 INV_14NM
X136 N135 N136 VDD 0 INV_14NM
X137 N136 N137 VDD 0 INV_14NM
X138 N137 N138 VDD 0 INV_14NM
X139 N138 N139 VDD 0 INV_14NM
X140 N139 N140 VDD 0 INV_14NM
X141 N140 N141 VDD 0 INV_14NM
X142 N141 N142 VDD 0 INV_14NM
X143 N142 N143 VDD 0 INV_14NM
X144 N143 N144 VDD 0 INV_14NM
X145 N144 N145 VDD 0 INV_14NM
X146 N145 N146 VDD 0 INV_14NM
X147 N146 N147 VDD 0 INV_14NM
X148 N147 N148 VDD 0 INV_14NM
X149 N148 N149 VDD 0 INV_14NM
X150 N149 N150 VDD 0 INV_14NM
X151 N150 N151 VDD 0 INV_14NM
X152 N151 N152 VDD 0 INV_14NM
X153 N152 N153 VDD 0 INV_14NM
X154 N153 N154 VDD 0 INV_14NM
X155 N154 N155 VDD 0 INV_14NM
X156 N155 N156 VDD 0 INV_14NM
X157 N156 N157 VDD 0 INV_14NM
X158 N157 N158 VDD 0 INV_14NM
X159 N158 N159 VDD 0 INV_14NM
X160 N159 N160 VDD 0 INV_14NM
X161 N160 N161 VDD 0 INV_14NM
X162 N161 N162 VDD 0 INV_14NM
X163 N162 N163 VDD 0 INV_14NM
X164 N163 N164 VDD 0 INV_14NM
X165 N164 N165 VDD 0 INV_14NM
X166 N165 N166 VDD 0 INV_14NM
X167 N166 N167 VDD 0 INV_14NM
X168 N167 N168 VDD 0 INV_14NM
X169 N168 N169 VDD 0 INV_14NM
X170 N169 N170 VDD 0 INV_14NM
X171 N170 N171 VDD 0 INV_14NM
X172 N171 N172 VDD 0 INV_14NM
X173 N172 N173 VDD 0 INV_14NM
X174 N173 N174 VDD 0 INV_14NM
X175 N174 N175 VDD 0 INV_14NM
X176 N175 N176 VDD 0 INV_14NM
X177 N176 N177 VDD 0 INV_14NM
X178 N177 N178 VDD 0 INV_14NM
X179 N178 N179 VDD 0 INV_14NM
X180 N179 N180 VDD 0 INV_14NM
X181 N180 N181 VDD 0 INV_14NM
X182 N181 N182 VDD 0 INV_14NM
X183 N182 N183 VDD 0 INV_14NM
X184 N183 N184 VDD 0 INV_14NM
X185 N184 N185 VDD 0 INV_14NM
X186 N185 N186 VDD 0 INV_14NM
X187 N186 N187 VDD 0 INV_14NM
X188 N187 N188 VDD 0 INV_14NM
X189 N188 N189 VDD 0 INV_14NM
X190 N189 N190 VDD 0 INV_14NM
X191 N190 N191 VDD 0 INV_14NM
X192 N191 N192 VDD 0 INV_14NM
X193 N192 N193 VDD 0 INV_14NM
X194 N193 N194 VDD 0 INV_14NM
X195 N194 N195 VDD 0 INV_14NM
X196 N195 N196 VDD 0 INV_14NM
X197 N196 N197 VDD 0 INV_14NM
X198 N197 N198 VDD 0 INV_14NM
X199 N198 N199 VDD 0 INV_14NM
X200 N199 N200 VDD 0 INV_14NM
X201 N200 N201 VDD 0 INV_14NM
X202 N201 N202 VDD 0 INV_14NM
X203 N202 N203 VDD 0 INV_14NM
X204 N203 N204 VDD 0 INV_14NM
X205 N204 N205 VDD 0 INV_14NM
X206 N205 N206 VDD 0 INV_14NM
X207 N206 N207 VDD 0 INV_14NM
X208 N207 N208 VDD 0 INV_14NM
X209 N208 N209 VDD 0 INV_14NM
X210 N209 N210 VDD 0 INV_14NM
X211 N210 N211 VDD 0 INV_14NM
X212 N211 N212 VDD 0 INV_14NM
X213 N212 N213 VDD 0 INV_14NM
X214 N213 N214 VDD 0 INV_14NM
X215 N214 N215 VDD 0 INV_14NM
X216 N215 N216 VDD 0 INV_14NM
X217 N216 N217 VDD 0 INV_14NM
X218 N217 N218 VDD 0 INV_14NM
X219 N218 N219 VDD 0 INV_14NM
X220 N219 N220 VDD 0 INV_14NM
X221 N220 N221 VDD 0 INV_14NM
X222 N221 N222 VDD 0 INV_14NM
X223 N222 N223 VDD 0 INV_14NM
X224 N223 N224 VDD 0 INV_14NM
X225 N224 N225 VDD 0 INV_14NM
X226 N225 N226 VDD 0 INV_14NM
X227 N226 N227 VDD 0 INV_14NM
X228 N227 N228 VDD 0 INV_14NM
X229 N228 N229 VDD 0 INV_14NM
X230 N229 N230 VDD 0 INV_14NM
X231 N230 N231 VDD 0 INV_14NM
X232 N231 N232 VDD 0 INV_14NM
X233 N232 N233 VDD 0 INV_14NM
X234 N233 N234 VDD 0 INV_14NM
X235 N234 N235 VDD 0 INV_14NM
X236 N235 N236 VDD 0 INV_14NM
X237 N236 N237 VDD 0 INV_14NM
X238 N237 N238 VDD 0 INV_14NM
X239 N238 N239 VDD 0 INV_14NM
X240 N239 N240 VDD 0 INV_14NM
X241 N240 N241 VDD 0 INV_14NM
X242 N241 N242 VDD 0 INV_14NM
X243 N242 N243 VDD 0 INV_14NM
X244 N243 N244 VDD 0 INV_14NM
X245 N244 N245 VDD 0 INV_14NM
X246 N245 N246 VDD 0 INV_14NM
X247 N246 N247 VDD 0 INV_14NM
X248 N247 N248 VDD 0 INV_14NM
X249 N248 N249 VDD 0 INV_14NM
X250 N249 OUT  VDD 0 INV_14NM

* ---- Input stimulus: single 0→1 transition at t=1ns ----
VIN IN 0 PULSE(0 {VDD} 1n 20p 20p 20n 40n)

* ---- Load capacitor at output (fan-out = 4 equiv) ----
CLOAD OUT 0 4f

* ---- Transient simulation: 30 ns window, 1 ps step ----
.TRAN 1p 30n

* ---- Measure propagation delay (50% crossing) ----
.MEAS TRAN t_in  WHEN V(IN)=0.4 RISE=1
.MEAS TRAN t_out WHEN V(OUT)=0.4 RISE=1
.MEAS TRAN T_comb PARAM='t_out - t_in'
.MEAS TRAN margin PARAM='12.98n - T_comb'

* ---- PVT corners — run .cir five times with these param sets ----
* Corner TT (nominal): corner_nmos=1.0, corner_pmos=1.0, VDD=0.8, TEMP=27
* Corner FF (fast):    corner_nmos=0.85,corner_pmos=0.85,VDD=0.88,TEMP=-40
* Corner SS (slow):    corner_nmos=1.2, corner_pmos=1.2, VDD=0.72,TEMP=125
* Corner FS (fast-n):  corner_nmos=0.85,corner_pmos=1.2, VDD=0.8, TEMP=27
* Corner SF (slow-n):  corner_nmos=1.2, corner_pmos=0.85,VDD=0.8, TEMP=27

.OPTIONS ACCURATE RELTOL=1e-6

.END
