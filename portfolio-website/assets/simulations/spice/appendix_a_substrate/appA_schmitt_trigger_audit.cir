* ============================================================
* appA_schmitt_trigger_audit.cir
* Appendix A — Theorem A.2: Schmitt Trigger Audit Frequency
* Purpose : Verify f_audit(T) ≥ (k_B T / ℏ) * ln(I_on/I_off)
*           across full operating temperature range.
*           Squaring-circuit topology drives f_audit dynamically
*           from substrate temperature T via thermal sensor.
* Simulator: ngspice / LTspice
* ============================================================

* ──── Physical constants ────
* k_B = 1.38065e-23  J/K  (Boltzmann)
* ℏ   = 1.05457e-34  J·s  (reduced Planck)
* → (k_B / ℏ) = 1.38065e-23 / 1.05457e-34 = 1.309e11  rad/(s·K)
.PARAM kB_over_hbar = 1.309e11    ; rad/(s·K)
.PARAM Ion_Ioff     = 1e7         ; I_on/I_off ratio (High-K gate, thesis §A)
.PARAM ln_ratio     = 16.118      ; ln(1e7) = 16.118

* ──── f_audit lower bound as function of T ────
* f_audit_min(T) = (k_B T / ℏ) * ln(I_on/I_off) / (2π)
*                = kB_over_hbar * ln_ratio / (2π) * T
.PARAM f_per_K = {kB_over_hbar * ln_ratio / (2 * 3.14159)}   ; Hz/K
* At T=300K: f_audit_min = 1.309e11 * 16.118 / 2π * 300 ≈ 1.0e14 Hz
* NOTE: This is the quantum-mechanical audit frequency LOWER BOUND.
* The actual Schmitt trigger frequency is a practical implementation
* that runs at a much lower "check rate" — the full quantum rate is
* the theoretical bound. Practical f_audit is set as a fraction:
.PARAM audit_fraction = 1e-6    ; practical audit at 1 ppm of quantum bound
.PARAM f_audit_nom = {f_per_K * 300 * audit_fraction}  ; practical audit freq

* ============================================================
* CMOS Schmitt Trigger (standard topology)
* Hysteresis ensures clean digital transitions from noisy analog input
* ============================================================
.PARAM VDD  = 0.8
.PARAM VTP  = -0.22
.PARAM VTN  =  0.22

.SUBCKT SCHMITT_TRIGGER IN OUT VDD VSS
* Inverter backbone
MP_MAIN  OUT IN VDD VDD PMOS_14NM W=14n L=14n
MN_MAIN  OUT IN VSS VSS NMOS_14NM W=7n  L=14n
* Positive feedback transistors (hysteresis)
MP_FB    VDD IN PFBNODE VDD PMOS_14NM W=7n L=14n
MN_FB    VSS IN NFBNODE VSS NMOS_14NM W=7n L=14n
* Feedback connection resistors
RFB_P PFBNODE OUT 5k
RFB_N NFBNODE OUT 5k
.ENDS SCHMITT_TRIGGER

* ──── MOSFET models ────
.MODEL NMOS_14NM NMOS LEVEL=1
+  VTO=0.22 KP=600u GAMMA=0.4 PHI=0.8 LAMBDA=0.1 TOX=1.2n

.MODEL PMOS_14NM PMOS LEVEL=1
+  VTO=-0.22 KP=250u GAMMA=0.4 PHI=0.8 LAMBDA=0.1 TOX=1.2n

* ============================================================
* Thermal sensor → f_audit squaring circuit
* Temperature is simulated as a swept DC parameter (.STEP TEMP)
* The sensor output V_T = k_B * T / q  (thermal voltage × log factor)
* ============================================================
.PARAM T_K = 300    ; override per .STEP TEMP run
.PARAM V_thermal = {1.38065e-23 * T_K / 1.60218e-19}   ; kT/q in Volts

* Thermal sensor voltage (proportional to T)
VTEMP_SENSOR VSENS 0 DC {V_thermal * ln_ratio}

* Squaring circuit: V_out_sq = (V_in)² / V_ref (translinear loop)
* Implemented as a simple VCVS square-law approximation
E_SQUARE V_SQUARED 0 VALUE={V(VSENS)*V(VSENS) / VDD}

* ── f_audit ring oscillator ──
* f_osc is set by RC time constant: f = 1/(2*R*C*ln(VDD/threshold))
* Controlled by V_SQUARED: larger T → higher V_SQUARED → smaller RC → higher f
R_OSC  V_SQUARED  OSC_NODE  R='1e6 / (1 + V(V_SQUARED)/0.01 * 1e3)'
C_OSC  OSC_NODE   0          10f
* Schmitt trigger on ring oscillator
XSCHMITT OSC_NODE F_AUDIT_OUT {VDD} 0 SCHMITT_TRIGGER

* ── Supply ──
VVDD VDD 0 DC {VDD}

* ── Ring oscillator stimulus ──
VIN_OSC OSC_NODE 0 PULSE(0 {VDD} 0 10p 10p {1/(2*f_audit_nom)} {1/f_audit_nom})

* ============================================================
* Temperature sweep: verify f_audit(T) ≥ f_audit_min(T)
* Run .STEP TEMP from -40 to 150, measure f_audit at each T
* ============================================================
.STEP TEMP -40 150 5

.TRAN 1p 100n

.MEAS TRAN f_audit TRIG V(F_AUDIT_OUT)=0.4 RISE=1
+                  TARG V(F_AUDIT_OUT)=0.4 RISE=2
.MEAS TRAN f_audit_Hz PARAM='1/(f_audit)'

* Compute theoretical minimum at current temperature
.MEAS TRAN f_audit_min_Hz PARAM='{f_per_K * (TEMP+273.15) * audit_fraction}'
.MEAS TRAN f_margin PARAM='f_audit_Hz - f_audit_min_Hz'
.MEAS TRAN f_passes PARAM='{f_audit_Hz >= f_audit_min_Hz}'

* ============================================================
* DC: Schmitt trigger transfer characteristic
* (Verify hysteresis thresholds V_L and V_H)
* ============================================================
VIN_DC IN_DC 0 DC 0
XSCHMITT_DC IN_DC OUT_DC {VDD} 0 SCHMITT_TRIGGER

* .DC VIN_DC 0 {VDD} 1m
* .MEAS DC V_THRESH_LOW  WHEN V(OUT_DC)=0.4 FALL=1
* .MEAS DC V_THRESH_HIGH WHEN V(OUT_DC)=0.4 RISE=1
* .MEAS DC HYSTERESIS PARAM='V_THRESH_HIGH - V_THRESH_LOW'

.OPTIONS ACCURATE RELTOL=1e-7

.END
